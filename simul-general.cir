*********************************************************************

.subckt avg 1 2
g1 0 3 cur = {v(1)}
c1 3 0 1 ic=0
r1 3 0 1meg
e1 2 0 vol = {v(3) / time}
r2 2 0 {1Meg}
.ends avg

*********************************************************************

.subckt buffer 1 2
e1 2 0 vol = v(1)
.ends buffer

*********************************************************************

.subckt const out K=1
e1 out 0 vol = {K}
r1 out 0 {1Meg}
.ends const

*********************************************************************

.subckt core k=1 L1=L1 L2=L2
k1 {L1} {L2} {k}
.ends core

*********************************************************************

.subckt sub 1 2 3
e1 3 0 vol = {v(1) - v(2)}
r1 3 0 {1Meg}
.ends sub

*********************************************************************

.subckt div 1 2 3
e1 3 0 vol = {v(1) / v(2)}
r1 3 0 {1Meg}
.ends div

*********************************************************************

.subckt gain 1 2 gain=1
e1 2 0 vol = {gain * v(1)}
r1 2 0 {1Meg}
.ends gain

*********************************************************************

.subckt int 1 2 tau=1u
g1 0 3 cur =  v(1)
c1 3 0 1 IC=0V
r1 3 0 1meg
e1 2 0 vol = '{v(3) > 0} ? {(1/tau) * v(3)} : {0}'
r2 2 0 {1Meg}
.ends int

*********************************************************************

.subckt isense 1 2 3
r1 1 2 0
e1 3 0 vol = {i(r1)}
r2 3 0 {1Meg}
.ends isense

*********************************************************************

.subckt pavg 1 2 3 4
r1 2 3 0
e1 5 0 vol = {(v(1) - v(2)) * i(r1)}
g1 0 6 cur = {v(5)}
c1 6 0 1 IC=0V
r2 6 0 1meg
e2 4 0 vol = {v(6) / time}
r3 4 0 {1Meg}
.ends pavg

*********************************************************************

.subckt pinst 1 2 3 4
r1 2 3 0
e1 4 0 vol = {(v(1) - v(2)) * i(r1)}
.ends pinst

*********************************************************************

.subckt power 1 2 3 4 5
r1 2 3 0
e1 5 0 vol = {(v(1) - v(2)) * i(r1)}
g1 0 6 cur = {v(5)}
c1 6 0 1 IC=0V
r2 6 0 1meg
e2 4 0 vol = {v(6) / time}
r3 4 0 {1Meg}
r4 5 0 {1Meg}
.ends power

*********************************************************************

.subckt mult 1 2 3
e1 3 0 vol = {v(1) * v(2)}
r1 3 0 {1Meg}
.ends mult

*********************************************************************

.subckt pwm 1 2 3 Ts=100u saw_min=0  saw_max=10 v_duty=5
v1 3 0 pulse({saw_min} {saw_max} 0 {0.998*Ts} {0.001*Ts} {0.001*Ts} {Ts})
e1 2 0 vol = {v(1) > v(3) ? {v_duty} : 0}
.ends pwm

*********************************************************************

.subckt pwrdiode 1 2
.model pwrd d
d1 1 2 pwrd
.ends pwrdiode

*********************************************************************

.subckt rvar 1 2 dt=1m Rmin=0 R1=0 R2=0 R3=0 R4=0 R5=0
r1 1 3 r = '{                    (time < (1*dt))} ? {R1} : {Rmin}'
r2 3 4 r = '{(time >= (1*dt)) && (time < (2*dt))} ? {R2} : {Rmin}'
r3 4 5 r = '{(time >= (2*dt)) && (time < (3*dt))} ? {R3} : {Rmin}'
r4 5 6 r = '{(time >= (3*dt)) && (time < (4*dt))} ? {R4} : {Rmin}'
r5 6 2 r = '{(time >= (4*dt))                   } ? {R5} : {Rmin}'
.ends rvar

*********************************************************************

.subckt add 1 2 3
e1 3 0 vol = {v(1) + v(2)}
r1 3 0 {1Meg}
.ends add

*********************************************************************

.subckt vcvs in out+ out- gain=1
e1 out+ out- vol = {gain * v(in)}
r1 out+ out- {1Meg}
.ends vcvs

*********************************************************************

.subckt vgate 1 2 V1=0 V2=5 TD=0 TR=0 TF=0 PW=500u Ts=1m
v1 1 2 dc 5 pulse({V1} {V2} {TD} {TR} {TF} {PW} {Ts})
.ends vgate

*********************************************************************

.subckt lookup_table 1 2
e1 2 0 TABLE {v(1)}
+     (  0,   0.0)
+     ( 25,  25.0)
+     ( 50,  50.0)
+     (100, 100.0)
+     (150, 150.0)
+     (200, 200.0)
.ends lookup_table

*********************************************************************

.end
